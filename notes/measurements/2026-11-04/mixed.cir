xspice mixed-signal smoke
v1 in 0 pulse(0 5 0 1n 1n 0.5m 1m)
abr1 [in] [din] adc1
.model adc1 adc_bridge(in_low=1 in_high=4)
ainv1 din dout inv1
.model inv1 d_inverter(rise_delay=10n fall_delay=10n)
adac1 [dout] [vout] dac1
.model dac1 dac_bridge(out_low=0 out_high=5)
r1 vout out 1k
c1 out 0 100n
.end
